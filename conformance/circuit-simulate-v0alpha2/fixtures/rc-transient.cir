OpenADA model-free RC transient conformance fixture
VSTEP in 0 PULSE(0 1 0 1n 1n 5u 10u)
R1 in out 1k
C1 out 0 1n
.tran 100n 2u
.end
