OpenADA model-free RC AC sweep fixture
VAC in 0 DC 0 AC 1
R1 in out 1k
C1 out 0 1u
.ac dec 5 10 10k
.end
