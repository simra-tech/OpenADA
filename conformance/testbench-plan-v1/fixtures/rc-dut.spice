* SPDX-License-Identifier: MIT
* Synthetic first-order RC DUT owned by the OpenADA project.
.SUBCKT RC_DUT IN OUT VDD VSS
R_INPUT IN OUT 1k
C_OUTPUT OUT VSS 1p
.ENDS RC_DUT
