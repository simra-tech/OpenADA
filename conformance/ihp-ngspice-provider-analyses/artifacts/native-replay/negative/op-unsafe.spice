** sch_path: /evidence/generated/inverter-source/inverter_tb.sch
**.subckt inverter_tb
V1 Vin GND PULSE(0 1.2 0.5u 10n 10n 1u 2u 1)
V2 Vdd GND 1.2
x1 Vdd Vin Vout GND inverter
**** begin user architecture code
.lib cornerMOSlv.lib mos_tt

**** end user architecture code
**.ends

* expanding   symbol:  inverter.sym # of pins=4
** sym_path: /evidence/generated/inverter-source/inverter.sym
** sch_path: /evidence/generated/inverter-source/inverter.sch
.subckt inverter Vdd Vin Vout Gnd
*.iopin Vout
*.iopin Vdd
*.iopin Vin
*.iopin Gnd
XM1 Gnd Vin Vout Gnd sg13_lv_nmos w=1.0u l=0.45u ng=1 m=1 mm_ok=1
XM2 Vout Vin Vdd Vdd sg13_lv_pmos w=2.0u l=0.45u ng=1 m=1 mm_ok=1
.ends

.GLOBAL GND

.control
save all
op
shell echo forbidden
write op.raw
.endc

.end
