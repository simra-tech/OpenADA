* SIMRA HIERARCHICAL STRUCTURAL EXPORT - unresolved identifiers must be bound before simulation.
.TITLE MODEL_FREE_DIFF_TB_V2
.SUBCKT MODEL_FREE_DIFF_DRIVER_V2 D DB OUTP OUTN VSS
E_N NDRV VSS DB VSS 1
E_P PDRV VSS D VSS 1
R_LOAD OUTP OUTN 100
R_N NDRV OUTN 50
R_P PDRV OUTP 50
.ENDS MODEL_FREE_DIFF_DRIVER_V2
V_GND VSS 0 DC 0
V_D D VSS DC 100m PULSE(100m 1.1 1n 100p 100p 4n 10n)
V_DB DB VSS DC 1.1 PULSE(1.1 100m 1n 100p 100p 4n 10n)
X_DUT D DB OUTP OUTN VSS MODEL_FREE_DIFF_DRIVER_V2
.SAVE D DB OUTP OUTN
.OP
.TRAN 100p 20n
.END
